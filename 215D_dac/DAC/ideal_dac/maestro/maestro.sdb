ADE simulation setup
Run mode: Single Run, Sweeps and Corners
Tests:
  DAC_ideal_dac_1: DAC/ideal_dac/schematic, simulator spectre
