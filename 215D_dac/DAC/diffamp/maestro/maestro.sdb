ADE simulation setup
Run mode: Monte Carlo Sampling
Tests:
  DAC_diffamp_1: DAC/diffamp/schematic, simulator spectre
    Variables: VDD = 1.8; corner = "tt"
Corners (nominal off):
  C0: corner="tt"
  C1 (off): corner="ff"
  C2 (off): corner="ss"
  C3 (off): corner="fs"
  C4 (off): corner="sf"
Monte Carlo Sampling options: ignoremode=default, mismatchvary=Gaussian, sssnumpoints=7000, mismatchscale=1.0, processscale=1.0, pointsPerJobPolicy=Group automatically, maxPointsPerJob=10, reliabilitymode=singlestress, wcdinitialpoints=200, mcnumpoints=500, yeyistostart=3.0, mcSigmaTarget=3, yeiterations=10, processvary=Gaussian, yeexpectedyield=3, mcmethod=mismatch, yeusehistorymc=0, yeuseautomcsamples=1, yecreatecorners=0, mcdistandscalingmismatchenable=0, parasiticanalysis=0, mcFilterPluginEnabled=0, haveyeyieldtostart=1, yeusevarreduction=1, mcdistandscalingprocessenable=0
