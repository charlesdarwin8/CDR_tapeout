ADE simulation setup
Test DAC_diffamp_1: DAC/diffamp/schematic, simulator spectre
  Models: /w/class.1/ee/ee215d/ee215dt2/DesignKits/TSMC180PDK/PDK/tsmc18/../models/spectre/cr018gpii_v1d0.scs[tt_rfres_sa, tt_rfmvar, tt_rtmom, tt_disres, VAR(\, tt_rfesd, tt_mim, tt_fmom, tt_rfres_rpo, tt_m, tt_rfmim, tt_res, tt_bip, tt_bip3, tt_dio3, tt_3v, tt_na, tt_dio, tt_dio_m, tt_rfind, tt_dio_3m, tt_bbmvar, tt_rfres_hri, tt_3vna, tt_dio_dnw, tt_3m, tt_rfjvar, tt_rfmos, tt_rfsbd, tt_rfmvar_33, tt_rfmos33, tt_rffmom, stat_noise, stat, stat_mis]
  Variables: corner = "\"tt\""; VDD = 1.8
  Temperature: 27
  Analysis ac: start=1M stop=1G dec=50
  Analysis dc: (saves the operating point)
  Output v (/VOP /VON); ac dB20(V) = db((vfreq('ac "/VOP") - vfreq('ac "/VON")))
  Output ((VDC("/VOP") - VDC("/VON")) / Av)
  Output Av = abs(value((vfreq('ac "/VOP") - vfreq('ac "/VON")) 1000000))
  Signals: /VOP, /VON
Run mode: Monte Carlo Sampling
Corners (nominal off):
  C0: corner="tt"
  C1 (off): corner="ff"
  C2 (off): corner="ss"
  C3 (off): corner="fs"
  C4 (off): corner="sf"
Monte Carlo Sampling options: ignoremode=default, mismatchvary=Gaussian, sssnumpoints=7000, mismatchscale=1.0, processscale=1.0, pointsPerJobPolicy=Group automatically, maxPointsPerJob=10, reliabilitymode=singlestress, wcdinitialpoints=200, mcnumpoints=500, yeyistostart=3.0, mcSigmaTarget=3, yeiterations=10, processvary=Gaussian, yeexpectedyield=3, mcmethod=mismatch, yeusehistorymc=0, yeuseautomcsamples=1, yecreatecorners=0, mcdistandscalingmismatchenable=0, parasiticanalysis=0, mcFilterPluginEnabled=0, haveyeyieldtostart=1, yeusevarreduction=1, mcdistandscalingprocessenable=0
Setup values for test DAC_diffamp_1: corner = "tt"
