ADE simulation setup
Test tapeout_fullrate_tb_diffamp_selfbias_inv_1: tapeout_fullrate/tb_diffamp_selfbias_inv/config, simulator spectre
  Models: /w/class.1/ee/ee209b/ee209bta/TSMC180PDK/PDK/tsmc18/../models/spectre/cr018gpii_v1d0.scs[tt_rfres_sa, tt_rfmvar, tt_rtmom, tt_disres, tt, tt_rfesd, tt_mim, tt_fmom, tt_rfres_rpo, tt_m, tt_rfmim, tt_res, tt_bip, tt_bip3, tt_dio3, tt_3v, tt_na, tt_dio, tt_dio_m, tt_rfind, tt_dio_3m, tt_bbmvar, tt_rfres_hri, tt_3vna, tt_dio_dnw, tt_3m, tt_rfjvar, tt_rfmos, tt_rfsbd, tt_rfmvar_33, tt_rfmos33, tt_rffmom, stat_noise]
  Variables: vdd = 1.8; T = 333p; V_inpu_dc = 1.1; SEL = 0; f = 1/T
  Temperature: 27
  Analysis dc: (saves the operating point)
  Analysis tran: stop=1u errpreset=conservative
  Output VT("/VINP")
  Output VT("/VINM")
  Output VT("/VOUTP")
  Output VT("/VOUTM")
  Output eye_OUT = eyeDiagram(VT("/OUT") 9e-07 1e-06 (2 * 3.33e-10) ?triggerPeriod 3.33e-10 ?autoCenter t)
  Output eye_randJitterLeft = eyeMeasurement(eyeDiagram(VT("/OUT") 9e-07 1e-06 (2 * 3.33e-10) ?triggerPeriod 3.33e-10 ?autoCenter t) 9e-07 1e-06 6.66e-10 0.9 nil t 40.0 0.0 t 60.0 50.0 t 40.0 50.0 t 60.0 100.0 100.0 "randJitterLeft")
  Output eye_p2pJitterLeft = eyeMeasurement(eyeDiagram(VT("/OUT") 9e-07 1e-06 (2 * 3.33e-10) ?triggerPeriod 3.33e-10 ?autoCenter t) 9e-07 1e-06 6.66e-10 0.9 nil t 40.0 0.0 t 60.0 50.0 t 40.0 50.0 t 60.0 100.0 100.0 "p2pJitterLeft")
  Output eye_VOUTP = eyeDiagram(VT("/VOUTP") 2e-07 3e-07 (2 * 3.33e-10) ?triggerPeriod 3.33e-10 ?autoCenter t)
  Output VOUTP_p2p_jitter_0.877_vth = eyeMeasurement(eyeDiagram(VT("/VOUTP") 2e-07 3e-07 (2 * 3.33e-10) ?triggerPeriod 3.33e-10 ?autoCenter t) 2e-07 3e-07 6.66e-10 0.877 nil t 40.0 0.0 t 60.0 50.0 t 40.0 50.0 t 60.0 100.0 100.0 "p2pJitterRight")
  Output VOUTP_p2p_jitter_0.9_vth = eyeMeasurement(eyeDiagram(VT("/VOUTP") 2e-07 3e-07 (2 * 3.33e-10) ?triggerPeriod 3.33e-10 ?autoCenter t) 2e-07 3e-07 6.66e-10 0.9 nil t 40.0 0.0 t 60.0 50.0 t 40.0 50.0 t 60.0 100.0 100.0 "p2pJitterRight")
  Output (VT("/I0/vo1") - VT("/I0/I4/vi"))
  Output eyeDiagram(VT("/OUT") 7e-07 8e-06 (2 * 3.33e-10) ?triggerPeriod 3.33e-10 ?autoCenter t)
  Output eyeDiagram(VT("/OUT") 4e-07 1e-06 (2 * 3.33e-10) ?triggerPeriod 3.33e-10 ?autoCenter t)
  Output eyeDiagram(VT("/VOUTP") 4e-07 1e-06 (2 * 3.33e-10) ?triggerPeriod 3.33e-10 ?autoCenter t)
  Output VT("/I0/Va")
  Output VT("/I0/Vb")
  Output VT("/I0/vo1")
  Output VT("/I0/vo2")
  Output eyeDiagram(VT("/I0/Va") 2e-07 3e-07 (2 * 3.33e-10) ?triggerPeriod 3.33e-10 ?autoCenter t)
  Output eyeDiagram(VT("/I0/vo1") 2e-07 3e-07 (2 * 3.33e-10) ?triggerPeriod 3.33e-10 ?autoCenter t)
  Output eyeDiagram(VT("/VOUTP") 2e-07 3e-07 (2 * 3.33e-10) ?triggerPeriod 3.33e-10 ?autoCenter t)
  Output eyeDiagram(VT("/OUT") 2e-07 3e-07 (2 * 3.33e-10) ?triggerPeriod 3.33e-10 ?autoCenter t)
  Output IT("/V0/PLUS")
  Signals: /VINP, /VINM, /VOUTP, /VOUTM, /I0/Va, /I0/Vb, /I0/vo1, /I0/vo2, /OUT, /I0/I4/vi, /V0/PLUS (terminal)
Run mode: Single Run, Sweeps and Corners
