ADE simulation setup
Run mode: Single Run, Sweeps and Corners
Tests:
  tapeout_fullrate_tb_diffamp_selfbias_inv_1: tapeout_fullrate/tb_diffamp_selfbias_inv/config, simulator spectre
    Variables: vdd = 1.8; T = 333p; V_inpu_dc = 1.1; f = 1/T; SEL = 0
    Outputs: eye_OUT; eye_randJitterLeft; eye_p2pJitterLeft; eye_VOUTP; VOUTP_p2p_jitter_0.877_vth; VOUTP_p2p_jitter_0.9_vth; eyeDiagram(VT("/OUT") 7e-07 8e-06 (2 * 3.33e-10) ?triggerPeriod 3.33e-10 ?autoCenter t); eyeDiagram(VT("/VOUT") 4e-07 1e-06 (2 * 3.33e-10) ?triggerPeriod 3.33e-10 ?autoCenter t); eyeDiagram(VT("/VOUTP") 4e-07 1e-06 (2 * 3.33e-10) ?triggerPeriod 3.33e-10 ?autoCenter t); eyeDiagram(VT("/OUT") 4e-07 1e-06 (2 * 3.33e-10) ?triggerPeriod 3.33e-10 ?autoCenter t)
