ADE simulation setup
Run mode: Single Run, Sweeps and Corners
Tests:
  tapeout_fullrate_tb_top_full_chip_1: tapeout_fullrate/tb_top_full_chip/config, simulator spectre
    Variables: C2 = 1.5p; R_filter = 400; vdd = 1.8; T = 333p; V_inpu_dc = 1.1; Vctrl_init = 1; SEL = vdd 0; RSEL = vdd; f = 1/T
    Outputs: clk_eye_2.5_to_5u_1ui; VT("/I0/XDIFFAMP_INV/VO2"); eyeDiagram(VT("/I0/XDIFFAMP_INV_VA") 3e-07 7e-07 (2 * 3.33e-10) ?triggerPeriod 3.33e-10 ?autoCenter t); eyeDiagram(VT("/I0/XDIFFAMP_INV_VO1") 3e-07 7e-07 (2 * 3.33e-10) ?triggerPeriod 3.33e-10 ?autoCenter t); freq(VT("/I0/XCDR_CLK") "rising" ?xName "cycle" ?mode "user" ?threshold (VAR("vdd") / 2)); VT("/I0/XCDR_VCTRL"); VT("/I0/S3"); eyeDiagram(clip(VT("/DATA_OSC") 2.5e-06 7.5e-06) 2.5e-06 7.5e-06 (2 * 1.665e-10) ?triggerPeriod 1.665e-10 ?autoCenter t); eyeDiagram(VT("/I0/DIN") 2e-06 5e-06 (2 * 3.33e-10) ?triggerPeriod 3.33e-10 ?autoCenter t); eyeDiagram(clip(VT("/CLK_OSC") 2e-06 5e-06) 2e-06 5e-06 (2 * 3.33e-10) ?triggerPeriod 3.33e-10 ?autoCenter t ?intensityPlot t); eyeDiagram(clip(VT("/DATA_OSC") 2e-06 7.5e-06) 2.5e-06 7.5e-06 (2 * 1.665e-10) ?triggerPeriod 1.665e-10 ?autoCenter t); eyeDiagram(clip(VT("/DATA_OSC") 2e-06 7.5e-06) 2e-06 7.5e-06 (2 * 1.665e-10) ?triggerPeriod 1.665e-10 ?autoCenter t); VT("/I0/VCTRL"); freq(VT("/VO2") "rising" ?xName "cycle" ?mode "user" ?threshold (VAR("vdd") / 2))
