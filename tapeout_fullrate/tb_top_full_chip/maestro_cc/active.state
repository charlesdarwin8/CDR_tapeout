ADE simulation setup
Test tapeout_fullrate_tb_top_full_chip_1: tapeout_fullrate/tb_top_full_chip/config, simulator spectre
  Models: /w/class.1/ee/ee209b/ee209bta/TSMC180PDK/PDK/tsmc18/../models/spectre/cr018gpii_v1d0.scs[tt_rfres_sa, tt_rfmvar, tt_rtmom, tt_disres, tt, tt_rfesd, tt_mim, tt_fmom, tt_rfres_rpo, tt_m, tt_rfmim, tt_res, tt_bip, tt_bip3, tt_dio3, tt_3v, tt_na, tt_dio, tt_dio_m, tt_rfind, tt_dio_3m, tt_bbmvar, tt_rfres_hri, tt_3vna, tt_dio_dnw, tt_3m, tt_rfjvar, tt_rfmos, tt_rfsbd, tt_rfmvar_33, tt_rfmos33, tt_rffmom, stat_noise]
  Variables: C2 = 1.5p; R_filter = 400; vdd = 1.8; T = 333p; V_inpu_dc = 1.1; Vctrl_init = 1; SEL = 1; RSEL = vdd; f = 1/T
  Temperature: 27
  Initial conditions: /VCAP = Vctrl_init
  Analysis dc: (saves the operating point)
  Analysis tran: stop=5u errpreset=conservative
  Output VT("/I0/VOUTP")
  Output VT("/I0/VOUTM")
  Output (VT("/I0/XDIFFAMP_INV_VO1") - VT("/I0/XDIFFAMP_INV_XI4_VI"))
  Output eyeDiagram(VT("/I0/DIN") 3e-07 1e-06 (2 * 3.33e-10) ?triggerPeriod 3.33e-10 ?autoCenter t)
  Output eyeDiagram(VT("/I0/VOUTP") 3e-07 1e-06 (2 * 3.33e-10) ?triggerPeriod 3.33e-10 ?autoCenter t)
  Output VT("/I0/XDIFFAMP_INV_VA")
  Output VT("/I0/XDIFFAMP_INV_VB")
  Output VT("/I0/XDIFFAMP_INV_VO1")
  Output VT("/I0/XDIFFAMP_INV_VO2")
  Output eyeDiagram(VT("/I0/XDIFFAMP_INV_VA") 3e-07 7e-07 (2 * 3.33e-10) ?triggerPeriod 3.33e-10 ?autoCenter t)
  Output eyeDiagram(VT("/I0/XDIFFAMP_INV_VO1") 3e-07 7e-07 (2 * 3.33e-10) ?triggerPeriod 3.33e-10 ?autoCenter t)
  Output freq(VT("/I0/XCDR_CLK") "rising" ?xName "cycle" ?mode "user" ?threshold (VAR("vdd") / 2))
  Output VT("/I0/DIN")
  Output v("/VCAP" ?result "tran")
  Output VT("/I0/XCDR_VCTRL")
  Output VT("/I0/XCDR_DIFFINP")
  Output VT("/I0/XCDR_DIFFINM")
  Output IT("/I0/XCDR_XILF_VCTRL")
  Output VT("/I0/XCDR_S1")
  Output VT("/I0/XCDR_S2")
  Output VT("/I0/S3")
  Output clk_eye_2.5_to_5u_1ui = eyeDiagram(clip(VT("/I0/XCDR_CLK") 2.5e-06 5e-06) 2.5e-06 5e-06 (2 * 3.33e-10) ?triggerPeriod 3.33e-10 ?autoCenter t ?intensityPlot t)
  Output clk_eye_2.5_to_7.5u_1ui = eyeDiagram(clip(VT("/I0/XCDR_CLK") 2.5e-06 7.5e-06) 2.5e-06 7.5e-06 (2 * 3.33e-10) ?triggerPeriod 3.33e-10 ?autoCenter t ?intensityPlot t)
  Output 2.5_to_5u_clk_rj = eyeMeasurement(eyeDiagram(clip(VT("/I0/XCDR_CLK") 2.5e-06 5e-06) 2.5e-06 5e-06 (2 * 1.665e-10) ?triggerPeriod 1.665e-10 ?autoCenter t) 2.5e-06 5e-06 3.33e-10 0.9 nil t 40.0 0.0 t 60.0 50.0 t 40.0 50.0 t 60.0 100.0 100.0 "randJitterRight")
  Output 2.5_to_5u_clk_p2p_jitter = eyeMeasurement(eyeDiagram(clip(VT("/I0/XCDR_CLK") 2.5e-06 5e-06) 2.5e-06 5e-06 (2 * 1.665e-10) ?triggerPeriod 1.665e-10 ?autoCenter t) 2.5e-06 5e-06 3.33e-10 0.9 nil t 40.0 0.0 t 60.0 50.0 t 40.0 50.0 t 60.0 100.0 100.0 "p2pJitterRight")
  Output clk_eye_2.5_to_7.5u = eyeDiagram(clip(VT("/I0/XCDR_CLK") 2.5e-06 7.5e-06) 2.5e-06 7.5e-06 (2 * 1.665e-10) ?triggerPeriod 1.665e-10 ?autoCenter t)
  Output 2.5_to_7.5u_clk_rj = eyeMeasurement(eyeDiagram(clip(VT("/I0/XCDR_CLK") 2.5e-06 7.5e-06) 2.5e-06 7.5e-06 (2 * 1.665e-10) ?triggerPeriod 1.665e-10 ?autoCenter t) 2.5e-06 7.5e-06 3.33e-10 0.9 nil t 40.0 0.0 t 60.0 50.0 t 40.0 50.0 t 60.0 100.0 100.0 "randJitterLeft")
  Output 2.5_to_7.5u_clk_p2p_jitter = eyeMeasurement(eyeDiagram(clip(VT("/I0/XCDR_CLK") 2.5e-06 7.5e-06) 2.5e-06 7.5e-06 (2 * 1.665e-10) ?triggerPeriod 1.665e-10 ?autoCenter t) 2.5e-06 7.5e-06 3.33e-10 0.9 nil t 40.0 0.0 t 60.0 50.0 t 40.0 50.0 t 60.0 100.0 100.0 "p2pJitterLeft")
  Output IT("/IVDD/PLUS")
  Output IT("/IVDD_VCO/PLUS")
  Output eyeDiagram(clip(VT("/CLK_OSC") 2.5e-06 5e-06) 2.5e-06 5e-06 (2 * 3.33e-10) ?triggerPeriod 3.33e-10 ?autoCenter t ?intensityPlot t)
  Output eyeDiagram(clip(VT("/DATA_OSC") 2.5e-06 7.5e-06) 2.5e-06 7.5e-06 (2 * 1.665e-10) ?triggerPeriod 1.665e-10 ?autoCenter t)
  Signals: /I0/VOUTP, /I0/VOUTM, /I0/DIN, /IVDD/PLUS (terminal), /IVDD_VCO/PLUS (terminal), /I0/XCDR_CLK, /I0/XDIFFAMP_INV_VO1, /I0/XDIFFAMP_INV_XI4_VI, /I0/XDIFFAMP_INV_VA, /I0/XDIFFAMP_INV_VB, /I0/XDIFFAMP_INV_VO2, /I0/S3, /VCAP, /CLK_OSC, /DATA_OSC
Run mode: Single Run, Sweeps and Corners
Setup values for test tapeout_fullrate_tb_top_full_chip_1: SEL = vdd 0
