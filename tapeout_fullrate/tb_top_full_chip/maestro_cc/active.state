ADE simulation setup
Test tapeout_fullrate_tb_top_full_chip_1: tapeout_fullrate/tb_top_full_chip/config, simulator spectre
  Models: /w/class.1/ee/ee209b/ee209bta/TSMC180PDK/PDK/tsmc18/../models/spectre/cr018gpii_v1d0.scs[tt_rfres_sa, tt_rfmvar, tt_rtmom, tt_disres, tt, tt_rfesd, tt_mim, tt_fmom, tt_rfres_rpo, tt_m, tt_rfmim, tt_res, tt_bip, tt_bip3, tt_dio3, tt_3v, tt_na, tt_dio, tt_dio_m, tt_rfind, tt_dio_3m, tt_bbmvar, tt_rfres_hri, tt_3vna, tt_dio_dnw, tt_3m, tt_rfjvar, tt_rfmos, tt_rfsbd, tt_rfmvar_33, tt_rfmos33, tt_rffmom, stat_noise]
  Variables: C2 = 1.5p; R_filter = 400; vdd = 1.8; T = 333p; V_inpu_dc = 1.1; Vctrl_init = 1; SEL = vdd 0; RSEL = vdd; f = 1/T
  Temperature: 27
  Initial conditions: /VCAP = Vctrl_init
  Analysis dc: (saves the operating point)
  Analysis tran: stop=5u errpreset=conservative
  Output eyeDiagram(VT("/I0/DIN") 2e-06 5e-06 (2 * 3.33e-10) ?triggerPeriod 3.33e-10 ?autoCenter t)
  Output clk_eye_2.5_to_5u_1ui = eyeDiagram(clip(VT("/VO2") 2e-06 5e-06) 2e-06 5e-06 (2 * 3.33e-10) ?triggerPeriod 3.33e-10 ?autoCenter t ?intensityPlot t)
  Output eyeDiagram(clip(VT("/CLK_OSC") 2e-06 5e-06) 2e-06 5e-06 (2 * 3.33e-10) ?triggerPeriod 3.33e-10 ?autoCenter t ?intensityPlot t)
  Output eyeDiagram(clip(VT("/DATA_OSC") 2e-06 7.5e-06) 2e-06 7.5e-06 (2 * 1.665e-10) ?triggerPeriod 1.665e-10 ?autoCenter t)
  Output eyeDiagram(clip(VT("/I0/S3") 2e-06 7.5e-06) 2e-06 7.5e-06 (2 * 1.665e-10) ?triggerPeriod 1.665e-10 ?autoCenter t)
  Output average(clip(IT("/IVDD/PLUS") 2000000.0 4000000.0))
  Output average(clip(IT("/IVDD_VCO/PLUS") 2000000.0 4000000.0))
  Output v("/VCAP" ?result "tran")
  Output VT("/I0/VCTRL")
  Output freq(VT("/VO2") "rising" ?xName "cycle" ?mode "user" ?threshold (VAR("vdd") / 2))
  Output VT("/I0/DIN")
  Output VT("/I0/S3")
  Output IT("/IVDD/PLUS")
  Output IT("/IVDD_VCO/PLUS")
  Output VT("/VO2")
  Signals: /I0/DIN, /IVDD/PLUS (terminal), /IVDD_VCO/PLUS (terminal), /I0/S3, /VCAP, /CLK_OSC, /DATA_OSC, /I0/VCTRL, /VO2
Run mode: Single Run, Sweeps and Corners
