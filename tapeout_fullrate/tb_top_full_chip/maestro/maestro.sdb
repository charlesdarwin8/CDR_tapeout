ADE simulation setup
Run mode: Single Run, Sweeps and Corners
Tests:
  tapeout_fullrate_tb_top_full_chip_1: tapeout_fullrate/tb_top_full_chip/schematic, simulator spectre
    Variables: vdd = 1.8; T = 333p; V_inpu_dc = 1.1; SEL = vdd; f = 1/T; C2 = 1.5p; R_filter = 400; Vctrl_init = 1
    Outputs: clk_eye_2.5_to_5u_1ui; clk_eye_2.5_to_7.5u_1ui; 2.5_to_5u_clk_rj; 2.5_to_5u_clk_p2p_jitter; clk_eye_2.5_to_7.5u; 2.5_to_7.5u_clk_rj; 2.5_to_7.5u_clk_p2p_jitter; VT("/I0/CDR/CLK"); freq(VT("/I0/CDR/CLK") "rising" ?xName "cycle" ?mode "user" ?threshold (VAR("vdd") / 2))
