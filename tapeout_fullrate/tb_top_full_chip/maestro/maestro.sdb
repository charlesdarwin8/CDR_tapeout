ADE simulation setup
Run mode: Single Run, Sweeps and Corners
Tests:
  tapeout_fullrate_tb_top_full_chip_1: tapeout_fullrate/tb_top_full_chip/schematic, simulator spectre
    Variables: vdd = 1.8; T = 333p; V_inpu_dc = 1.1; SEL = 0 vdd; f = 1/T; C2 = 1.5p; R_filter = 400; Vctrl_init = 1; RSEL = vdd
    Outputs: clk_eye_2.5_to_5u_1ui; clk_eye_2.5_to_7.5u_1ui; 2.5_to_5u_clk_rj; 2.5_to_5u_clk_p2p_jitter; clk_eye_2.5_to_7.5u; 2.5_to_7.5u_clk_rj; 2.5_to_7.5u_clk_p2p_jitter; VT("/I0/CDR/CLK"); freq(VT("/I0/CDR/CLK") "rising" ?xName "cycle" ?mode "user" ?threshold (VAR("vdd") / 2)); eyeDiagram(VT("/I0/DIFFAMP_INV/Va") 4e-07 7e-07 (2 * 3.33e-10) ?triggerPeriod 3.33e-10 ?autoCenter t); eyeDiagram(VT("/I0/DIFFAMP_INV/vo1") 4e-07 7e-07 (2 * 3.33e-10) ?triggerPeriod 3.33e-10 ?autoCenter t); eyeDiagram(VT("/I0/DIN") 3e-07 1e-06 (2 * 3.33e-10) ?triggerPeriod 3.33e-10 ?autoCenter t); eyeDiagram(VT("/I0/VOUTP") 3e-07 1e-06 (2 * 3.33e-10) ?triggerPeriod 3.33e-10 ?autoCenter t); eyeDiagram(VT("/I0/DIFFAMP_INV/Va") 3e-07 7e-07 (2 * 3.33e-10) ?triggerPeriod 3.33e-10 ?autoCenter t); eyeDiagram(VT("/I0/DIFFAMP_INV/vo1") 3e-07 7e-07 (2 * 3.33e-10) ?triggerPeriod 3.33e-10 ?autoCenter t); eyeDiagram(clip(VT("/CLK_OSC") 2.5e-06 5e-06) 2.5e-06 5e-06 (2 * 3.33e-10) ?triggerPeriod 3.33e-10 ?autoCenter t ?intensityPlot t); eyeDiagram(VT("/I0/DIFFAMP_INV/Va") 1e-07 7e-07 (2 * 3.33e-10) ?triggerPeriod 3.33e-10 ?autoCenter t); eyeDiagram(VT("/I0/DIFFAMP_INV/vo1") 1e-07 7e-07 (2 * 3.33e-10) ?triggerPeriod 3.33e-10 ?autoCenter t); eyeDiagram(clip(VT("/CLK_OSC") 1e-06 5e-06) 1e-06 5e-06 (2 * 3.33e-10) ?triggerPeriod 3.33e-10 ?autoCenter t ?intensityPlot t); eyeDiagram(clip(VT("/DATA_OSC") 1e-06 7.5e-06) 1e-06 7.5e-06 (2 * 1.665e-10) ?triggerPeriod 1.665e-10 ?autoCenter t); v("/I0/DIFFAMP_INV/Va" ?result "tran"); v("/I0/DIFFAMP_INV/Vo1" ?result "tran"); v("/I0/DIFFAMP_INV/Vb" ?result "tran"); v("/I0/DIFFAMP_INV/vo1" ?result "tran"); eyeDiagram(VT("/I0/DIN") 1e-07 5e-06 (2 * 3.33e-10) ?triggerPeriod 3.33e-10 ?autoCenter t); eyeDiagram(VT("/I0/VOUTP") 1e-07 5e-06 (2 * 3.33e-10) ?triggerPeriod 3.33e-10 ?autoCenter t); average(clip(IT("/IVDD/PLUS") 1e-06 3e-06))
