ADE simulation setup
Test tapeout_fullrate_tb_top_full_chip_1: tapeout_fullrate/tb_top_full_chip/schematic, simulator spectre
  Models: /w/class.1/ee/ee209b/ee209bta/TSMC180PDK/PDK/tsmc18/../models/spectre/cr018gpii_v1d0.scs[tt_rfres_sa, tt_rfmvar, tt_rtmom, tt_disres, tt, tt_rfesd, tt_mim, tt_fmom, tt_rfres_rpo, tt_m, tt_rfmim, tt_res, tt_bip, tt_bip3, tt_dio3, tt_3v, tt_na, tt_dio, tt_dio_m, tt_rfind, tt_dio_3m, tt_bbmvar, tt_rfres_hri, tt_3vna, tt_dio_dnw, tt_3m, tt_rfjvar, tt_rfmos, tt_rfsbd, tt_rfmvar_33, tt_rfmos33, tt_rffmom, stat_noise]
  Variables: C2 = 1.5p; R_filter = 400; vdd = 1.8; T = 333p; V_inpu_dc = 1.1; Vctrl_init = 1; SEL = 0; f = 1/T
  Temperature: 27
  Initial conditions: /VCAP_LF = Vctrl_init; /I0/CDR/VCTRL = Vctrl_init
  Analysis dc: (saves the operating point)
  Analysis tran: stop=7.5u errpreset=conservative
  Output VT("/I0/DIFFINP")
  Output VT("/I0/DIFFINM")
  Output VT("/I0/VOUTP")
  Output VT("/I0/VOUTM")
  Output eye_OUT = eyeDiagram(VT("/I0/DIN") 9e-07 1e-06 (2 * 3.33e-10) ?triggerPeriod 3.33e-10 ?autoCenter t)
  Output eye_randJitterLeft = eyeMeasurement(eyeDiagram(VT("/I0/DIN") 9e-07 1e-06 (2 * 3.33e-10) ?triggerPeriod 3.33e-10 ?autoCenter t) 9e-07 1e-06 6.66e-10 0.9 nil t 40.0 0.0 t 60.0 50.0 t 40.0 50.0 t 60.0 100.0 100.0 "randJitterLeft")
  Output eye_p2pJitterLeft = eyeMeasurement(eyeDiagram(VT("/I0/DIN") 9e-07 1e-06 (2 * 3.33e-10) ?triggerPeriod 3.33e-10 ?autoCenter t) 9e-07 1e-06 6.66e-10 0.9 nil t 40.0 0.0 t 60.0 50.0 t 40.0 50.0 t 60.0 100.0 100.0 "p2pJitterLeft")
  Output eye_VOUTP = eyeDiagram(VT("/I0/VOUTP") 2e-07 3e-07 (2 * 3.33e-10) ?triggerPeriod 3.33e-10 ?autoCenter t)
  Output VOUTP_p2p_jitter_0.877_vth = eyeMeasurement(eyeDiagram(VT("/I0/VOUTP") 2e-07 3e-07 (2 * 3.33e-10) ?triggerPeriod 3.33e-10 ?autoCenter t) 2e-07 3e-07 6.66e-10 0.877 nil t 40.0 0.0 t 60.0 50.0 t 40.0 50.0 t 60.0 100.0 100.0 "p2pJitterRight")
  Output VOUTP_p2p_jitter_0.9_vth = eyeMeasurement(eyeDiagram(VT("/I0/VOUTP") 2e-07 3e-07 (2 * 3.33e-10) ?triggerPeriod 3.33e-10 ?autoCenter t) 2e-07 3e-07 6.66e-10 0.9 nil t 40.0 0.0 t 60.0 50.0 t 40.0 50.0 t 60.0 100.0 100.0 "p2pJitterRight")
  Output (VT("/I0/DIFFAMP_INV/vo1") - VT("/I0/DIFFAMP_INV/I4/vi"))
  Output eyeDiagram(VT("/I0/DIN") 7e-07 8e-06 (2 * 3.33e-10) ?triggerPeriod 3.33e-10 ?autoCenter t)
  Output eyeDiagram(VT("/I0/DIN") 4e-07 1e-06 (2 * 3.33e-10) ?triggerPeriod 3.33e-10 ?autoCenter t)
  Output eyeDiagram(VT("/I0/VOUTP") 4e-07 1e-06 (2 * 3.33e-10) ?triggerPeriod 3.33e-10 ?autoCenter t)
  Output VT("/I0/DIFFAMP_INV/Va")
  Output VT("/I0/DIFFAMP_INV/Vb")
  Output VT("/I0/DIFFAMP_INV/vo1")
  Output VT("/I0/DIFFAMP_INV/vo2")
  Output eyeDiagram(VT("/I0/DIFFAMP_INV/Va") 2e-07 3e-07 (2 * 3.33e-10) ?triggerPeriod 3.33e-10 ?autoCenter t)
  Output eyeDiagram(VT("/I0/DIFFAMP_INV/vo1") 2e-07 3e-07 (2 * 3.33e-10) ?triggerPeriod 3.33e-10 ?autoCenter t)
  Output eyeDiagram(VT("/I0/VOUTP") 2e-07 3e-07 (2 * 3.33e-10) ?triggerPeriod 3.33e-10 ?autoCenter t)
  Output VT("/I0/CDR/CLK")
  Output freq(VT("/I0/CDR/CLK") "rising" ?xName "cycle" ?mode "user" ?threshold (VAR("vdd") / 2))
  Output VT("/I0/DIN")
  Output VT("/I0/CDR/VCTRL")
  Output VT("/I0/CDR/DIFFINP")
  Output VT("/I0/CDR/DIFFINM")
  Output IT("/I0/CDR/ILF/VCTRL")
  Output VT("/I0/CDR/S1")
  Output VT("/I0/CDR/S2")
  Output VT("/I0/CDR/S3")
  Output clk_eye_2.5_to_5u_1ui = eyeDiagram(clip(VT("/I0/CDR/CLK") 2.5e-06 5e-06) 2.5e-06 5e-06 (2 * 3.33e-10) ?triggerPeriod 3.33e-10 ?autoCenter t ?intensityPlot t)
  Output clk_eye_2.5_to_7.5u_1ui = eyeDiagram(clip(VT("/I0/CDR/CLK") 2.5e-06 7.5e-06) 2.5e-06 7.5e-06 (2 * 3.33e-10) ?triggerPeriod 3.33e-10 ?autoCenter t ?intensityPlot t)
  Output 2.5_to_5u_clk_rj = eyeMeasurement(eyeDiagram(clip(VT("/I0/CDR/CLK") 2.5e-06 5e-06) 2.5e-06 5e-06 (2 * 1.665e-10) ?triggerPeriod 1.665e-10 ?autoCenter t) 2.5e-06 5e-06 3.33e-10 0.9 nil t 40.0 0.0 t 60.0 50.0 t 40.0 50.0 t 60.0 100.0 100.0 "randJitterRight")
  Output 2.5_to_5u_clk_p2p_jitter = eyeMeasurement(eyeDiagram(clip(VT("/I0/CDR/CLK") 2.5e-06 5e-06) 2.5e-06 5e-06 (2 * 1.665e-10) ?triggerPeriod 1.665e-10 ?autoCenter t) 2.5e-06 5e-06 3.33e-10 0.9 nil t 40.0 0.0 t 60.0 50.0 t 40.0 50.0 t 60.0 100.0 100.0 "p2pJitterRight")
  Output clk_eye_2.5_to_7.5u = eyeDiagram(clip(VT("/I0/CDR/CLK") 2.5e-06 7.5e-06) 2.5e-06 7.5e-06 (2 * 1.665e-10) ?triggerPeriod 1.665e-10 ?autoCenter t)
  Output 2.5_to_7.5u_clk_rj = eyeMeasurement(eyeDiagram(clip(VT("/I0/CDR/CLK") 2.5e-06 7.5e-06) 2.5e-06 7.5e-06 (2 * 1.665e-10) ?triggerPeriod 1.665e-10 ?autoCenter t) 2.5e-06 7.5e-06 3.33e-10 0.9 nil t 40.0 0.0 t 60.0 50.0 t 40.0 50.0 t 60.0 100.0 100.0 "randJitterLeft")
  Output 2.5_to_7.5u_clk_p2p_jitter = eyeMeasurement(eyeDiagram(clip(VT("/I0/CDR/CLK") 2.5e-06 7.5e-06) 2.5e-06 7.5e-06 (2 * 1.665e-10) ?triggerPeriod 1.665e-10 ?autoCenter t) 2.5e-06 7.5e-06 3.33e-10 0.9 nil t 40.0 0.0 t 60.0 50.0 t 40.0 50.0 t 60.0 100.0 100.0 "p2pJitterLeft")
  Signals: /I0/DIFFINP, /I0/DIFFINM, /I0/VOUTP, /I0/VOUTM, /I0/DIN, /I0/DIFFAMP_INV/vo1, /I0/DIFFAMP_INV/I4/vi, /I0/DIFFAMP_INV/Va, /I0/DIFFAMP_INV/Vb, /I0/DIFFAMP_INV/vo2, /I0/CDR/VCTRL, /I0/CDR/ILF/VCTRL (terminal), /I0/CDR/S1, /I0/CDR/S2, /I0/CDR/S3, /I0/CDR/CLK
Run mode: Single Run, Sweeps and Corners
Setup values for test tapeout_fullrate_tb_top_full_chip_1: SEL = vdd
