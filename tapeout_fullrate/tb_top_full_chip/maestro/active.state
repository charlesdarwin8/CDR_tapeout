ADE simulation setup
Test tapeout_fullrate_tb_top_full_chip_1: tapeout_fullrate/tb_top_full_chip/schematic, simulator spectre
  Models: /w/class.1/ee/ee209b/ee209bta/TSMC180PDK/PDK/tsmc18/../models/spectre/cr018gpii_v1d0.scs[tt_rfres_sa, tt_rfmvar, tt_rtmom, tt_disres, tt, tt_rfesd, tt_mim, tt_fmom, tt_rfres_rpo, tt_m, tt_rfmim, tt_res, tt_bip, tt_bip3, tt_dio3, tt_3v, tt_na, tt_dio, tt_dio_m, tt_rfind, tt_dio_3m, tt_bbmvar, tt_rfres_hri, tt_3vna, tt_dio_dnw, tt_3m, tt_rfjvar, tt_rfmos, tt_rfsbd, tt_rfmvar_33, tt_rfmos33, tt_rffmom, stat_noise]
  Variables: C2 = 1.5p; R_filter = 400; vdd = 1.8; T = 333p; V_inpu_dc = 1.1; Vctrl_init = 1; SEL = 0 vdd; RSEL = vdd; f = 1/T
  Temperature: 27
  Initial conditions: /VCAP = Vctrl_init
  Analysis tran: stop=5u errpreset=conservative
  Analysis dc: (saves the operating point)
  Output VT("/I0/VOUTP")
  Output VT("/I0/VOUTM")
  Output (VT("/I0/DIFFAMP_INV/vo1") - VT("/I0/DIFFAMP_INV/I4/vi"))
  Output eyeDiagram(VT("/I0/DIN") 1e-07 5e-06 (2 * 3.33e-10) ?triggerPeriod 3.33e-10 ?autoCenter t)
  Output eyeDiagram(VT("/I0/VOUTP") 1e-07 5e-06 (2 * 3.33e-10) ?triggerPeriod 3.33e-10 ?autoCenter t)
  Output VT("/I0/DIFFAMP_INV/Va")
  Output VT("/I0/DIFFAMP_INV/Vb")
  Output VT("/I0/DIFFAMP_INV/vo1")
  Output VT("/I0/DIFFAMP_INV/vo2")
  Output eyeDiagram(VT("/I0/DIFFAMP_INV/Va") 1e-07 7e-07 (2 * 3.33e-10) ?triggerPeriod 3.33e-10 ?autoCenter t)
  Output eyeDiagram(VT("/I0/DIFFAMP_INV/vo1") 1e-07 7e-07 (2 * 3.33e-10) ?triggerPeriod 3.33e-10 ?autoCenter t)
  Output VT("/I0/CDR/CLK")
  Output freq(VT("/I0/CDR/CLK") "rising" ?xName "cycle" ?mode "user" ?threshold (VAR("vdd") / 2))
  Output VT("/I0/DIN")
  Output VT("/I0/CDR/VCTRL")
  Output IT("/I0/CDR/ILF/VCTRL")
  Output VT("/I0/CDR/S1")
  Output VT("/I0/CDR/S2")
  Output VT("/I0/CDR/S3")
  Output clk_eye_2.5_to_5u_1ui = eyeDiagram(clip(VT("/I0/CDR/CLK") 1e-06 5e-06) 1e-06 5e-06 (2 * 3.33e-10) ?triggerPeriod 3.33e-10 ?autoCenter t ?intensityPlot t)
  Output clk_eye_2.5_to_7.5u_1ui = eyeDiagram(clip(VT("/I0/CDR/CLK") 1e-06 7.5e-06) 1e-06 7.5e-06 (2 * 3.33e-10) ?triggerPeriod 3.33e-10 ?autoCenter t ?intensityPlot t)
  Output 2.5_to_5u_clk_rj = eyeMeasurement(eyeDiagram(clip(VT("/I0/CDR/CLK") 1e-06 5e-06) 1e-06 5e-06 (2 * 1.665e-10) ?triggerPeriod 1.665e-10 ?autoCenter t) 1e-06 5e-06 3.33e-10 0.9 nil t 40.0 0.0 t 60.0 50.0 t 40.0 50.0 t 60.0 100.0 100.0 "randJitterRight")
  Output 2.5_to_5u_clk_p2p_jitter = eyeMeasurement(eyeDiagram(clip(VT("/I0/CDR/CLK") 1e-06 5e-06) 1e-06 5e-06 (2 * 1.665e-10) ?triggerPeriod 1.665e-10 ?autoCenter t) 1e-06 5e-06 3.33e-10 0.9 nil t 40.0 0.0 t 60.0 50.0 t 40.0 50.0 t 60.0 100.0 100.0 "p2pJitterRight")
  Output clk_eye_2.5_to_7.5u = eyeDiagram(clip(VT("/I0/CDR/CLK") 1e-06 7.5e-06) 1e-06 7.5e-06 (2 * 1.665e-10) ?triggerPeriod 1.665e-10 ?autoCenter t)
  Output 2.5_to_7.5u_clk_rj = eyeMeasurement(eyeDiagram(clip(VT("/I0/CDR/CLK") 1e-06 7.5e-06) 1e-06 7.5e-06 (2 * 1.665e-10) ?triggerPeriod 1.665e-10 ?autoCenter t) 1e-06 7.5e-06 3.33e-10 0.9 nil t 40.0 0.0 t 60.0 50.0 t 40.0 50.0 t 60.0 100.0 100.0 "randJitterLeft")
  Output 2.5_to_7.5u_clk_p2p_jitter = eyeMeasurement(eyeDiagram(clip(VT("/I0/CDR/CLK") 1e-06 7.5e-06) 1e-06 7.5e-06 (2 * 1.665e-10) ?triggerPeriod 1.665e-10 ?autoCenter t) 1e-06 7.5e-06 3.33e-10 0.9 nil t 40.0 0.0 t 60.0 50.0 t 40.0 50.0 t 60.0 100.0 100.0 "p2pJitterLeft")
  Output IT("/IVDD/PLUS")
  Output IT("/IVDD_VCO/PLUS")
  Output eyeDiagram(clip(VT("/CLK_OSC") 1e-06 5e-06) 1e-06 5e-06 (2 * 3.33e-10) ?triggerPeriod 3.33e-10 ?autoCenter t ?intensityPlot t)
  Output eyeDiagram(clip(VT("/DATA_OSC") 1e-06 7.5e-06) 1e-06 7.5e-06 (2 * 1.665e-10) ?triggerPeriod 1.665e-10 ?autoCenter t)
  Output v("/I0/CDR/CLK" ?result "tran")
  Output v("/I0/CDR/VCTRL" ?result "tran")
  Output v("/I0/CDR/S1" ?result "tran")
  Output v("/I0/CDR/S2" ?result "tran")
  Output v("/I0/CDR/S3" ?result "tran")
  Output v("/I0/DIFFAMP_INV/Va" ?result "tran")
  Output v("/I0/DIFFAMP_INV/vo1" ?result "tran")
  Output v("/VCAP" ?result "tran")
  Output average(clip(IT("/IVDD/PLUS") 1e-06 3e-06))
  Output IT("/I0/DIFFAMP_INV/VDD")
  Output IT("/I0/I4/VDD")
  Output IT("/I0/CDR/VDD")
  Signals: /I0/VOUTP, /I0/VOUTM, /I0/DIN, /I0/DIFFAMP_INV/vo1, /I0/DIFFAMP_INV/Va, /I0/DIFFAMP_INV/Vb, /I0/CDR/VCTRL, /I0/CDR/S1, /I0/CDR/S2, /I0/CDR/S3, /I0/CDR/CLK, /IVDD/PLUS (terminal), /IVDD_VCO/PLUS (terminal), /CLKOUT, /DATA_OSC, /CLK_OSC, /VCAP, /I0/DIFFAMP_INV/VDD (terminal), /I0/I4/VDD (terminal), /I0/CDR/VDD (terminal)
Run mode: Single Run, Sweeps and Corners
Setup values for test tapeout_fullrate_tb_top_full_chip_1: SEL = vdd
