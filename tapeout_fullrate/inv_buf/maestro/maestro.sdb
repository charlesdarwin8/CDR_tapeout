ADE simulation setup
Run mode: Single Run, Sweeps and Corners
Tests:
  spring_work_inv_buf_1: spring_work/inv_buf/schematic, simulator spectre
    Variables: del = 166.5p
