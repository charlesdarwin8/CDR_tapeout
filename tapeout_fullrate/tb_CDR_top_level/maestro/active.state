ADE simulation setup
Test tapeout_fullrate_tb_CDR_top_level_1: tapeout_fullrate/tb_CDR_top_level/config, simulator spectre
  Models: /w/class.1/ee/ee209b/ee209bta/TSMC180PDK/PDK/tsmc18/../models/spectre/cr018gpii_v1d0.scs[tt_rfres_sa, tt_rfmvar, tt_rtmom, tt_disres, tt, tt_rfesd, tt_mim, tt_fmom, tt_rfres_rpo, tt_m, tt_rfmim, tt_res, tt_bip, tt_bip3, tt_dio3, tt_3v, tt_na, tt_dio, tt_dio_m, tt_rfind, tt_dio_3m, tt_bbmvar, tt_rfres_hri, tt_3vna, tt_dio_dnw, tt_3m, tt_rfjvar, tt_rfmos, tt_rfsbd, tt_rfmvar_33, tt_rfmos33, tt_rffmom, stat_noise]
  Variables: T = 333p; R_filter = 400; C2 = 1.5p; Vinit = 0.9; del = 0; vdd = 1.8
  Temperature: 27
  Initial conditions: /I0/VCTRL = Vinit
  Analysis tran: stop=5u errpreset=conservative
  Output VT("/CLK")
  Output freq(VT("/CLK") "rising" ?xName "cycle" ?mode "user" ?threshold (VAR("vdd") / 2))
  Output VT("/DIN")
  Output VT("/I0/VCTRL")
  Output VT("/I0/VINP")
  Output VT("/I0/VINM")
  Output IT("/I0/ILF/VCTRL")
  Output IT("/C0/PLUS")
  Output VT("/I0/S1")
  Output VT("/I0/S2")
  Output VT("/I0/S3")
  Output VT("/I0/S4")
  Output average(clip(IT("/C0/PLUS") 4e-06 8e-06))
  Output ((VT("/out") + VT("/outb")) / 2)
  Output clk_eye_2.5_to_5u_1ui = eyeDiagram(clip(VT("/CLK") 2.5e-06 5e-06) 2.5e-06 5e-06 (2 * 3.33e-10) ?triggerPeriod 3.33e-10 ?autoCenter t ?intensityPlot t)
  Output clk_eye_2.5_to_7.5u_1ui = eyeDiagram(clip(VT("/CLK") 2.5e-06 7.5e-06) 2.5e-06 7.5e-06 (2 * 3.33e-10) ?triggerPeriod 3.33e-10 ?autoCenter t ?intensityPlot t)
  Output 2.5_to_5u_clk_rj = eyeMeasurement(eyeDiagram(clip(VT("/CLK") 2.5e-06 5e-06) 2.5e-06 5e-06 (2 * 1.665e-10) ?triggerPeriod 1.665e-10 ?autoCenter t) 2.5e-06 5e-06 3.33e-10 0.9 nil t 40.0 0.0 t 60.0 50.0 t 40.0 50.0 t 60.0 100.0 100.0 "randJitterRight")
  Output 2.5_to_5u_clk_p2p_jitter = eyeMeasurement(eyeDiagram(clip(VT("/CLK") 2.5e-06 5e-06) 2.5e-06 5e-06 (2 * 1.665e-10) ?triggerPeriod 1.665e-10 ?autoCenter t) 2.5e-06 5e-06 3.33e-10 0.9 nil t 40.0 0.0 t 60.0 50.0 t 40.0 50.0 t 60.0 100.0 100.0 "p2pJitterRight")
  Output clk_eye_2.5_to_7.5u = eyeDiagram(clip(VT("/CLK") 2.5e-06 7.5e-06) 2.5e-06 7.5e-06 (2 * 1.665e-10) ?triggerPeriod 1.665e-10 ?autoCenter t)
  Output 2.5_to_7.5u_clk_rj = eyeMeasurement(eyeDiagram(clip(VT("/CLK") 2.5e-06 7.5e-06) 2.5e-06 7.5e-06 (2 * 1.665e-10) ?triggerPeriod 1.665e-10 ?autoCenter t) 2.5e-06 7.5e-06 3.33e-10 0.9 nil t 40.0 0.0 t 60.0 50.0 t 40.0 50.0 t 60.0 100.0 100.0 "randJitterLeft")
  Output 2.5_to_7.5u_clk_p2p_jitter = eyeMeasurement(eyeDiagram(clip(VT("/CLK") 2.5e-06 7.5e-06) 2.5e-06 7.5e-06 (2 * 1.665e-10) ?triggerPeriod 1.665e-10 ?autoCenter t) 2.5e-06 7.5e-06 3.33e-10 0.9 nil t 40.0 0.0 t 60.0 50.0 t 40.0 50.0 t 60.0 100.0 100.0 "p2pJitterLeft")
  Signals: /CLK, /DIN, /S1, /I0/VINM, /I0/VINP, /I0/S1, /I0/S2, /I0/S3, /I0/VCTRL, /I0/ILF/VCTRL (terminal), /I0/VO1, /I0/IVCOBUFP/net1
Run mode: Single Run, Sweeps and Corners
Corners:
  model folders: /w/class.1/ee/ee209b/ee209bta/TSMC180PDK/PDK/tsmc18/../models/spectre
  every corner: /w/class.1/ee/ee209b/ee209bta/TSMC180PDK/PDK/tsmc18/../models/spectre/cr018gpii_v1d0.scs[stat_noise]
  SS (off): cr018gpii_v1d0.scs[ss, ss_mim, ss_res, ss_bbmvar]
  FF (off): cr018gpii_v1d0.scs[ff, ff_mim, ff_res, ff_bbmvar]
  TT_noise (off): cr018gpii_v1d0.scs[tt, tt_mim, tt_bbmvar, tt_res]
