ADE simulation setup
Run mode: Single Run, Sweeps and Corners
Tests:
  tapeout_fullrate_tb_CDR_top_level_1: tapeout_fullrate/tb_CDR_top_level/config, simulator spectre
    Variables: vdd = 1.8; R_filter = 400; C2 = 1.5p; Vinit = 0.9; del = 0; T = 333p; f = 1/T
    Outputs: VO_avg; Vo1_max; Vo1_min; pk-pk_swing; VT("/I0//VO1"); VT("/I0//VO2"); ((VT("/I0//VO1") + VT("/VO2")) / 2); ((VT("/I0//VO1") + VT("/I0//VO2")) / 2); freq; VT("/I0//S1"); VT("/I0//S2"); VT("/I0//S3"); VT("/I0//S4"); VT("/I0//VINP"); VT("/I0//VINM"); VT("/I0/VINM"); VT("/I0/VINP"); VT("/I0/S1"); VT("/I0/S2"); VT("/I0/S3"); VT("/I0/VCTRL"); clk_eye_2.5_to_5u_1ui
Corners:
  model folders: /w/class.1/ee/ee209b/ee209bta/TSMC180PDK/PDK/tsmc18/../models/spectre
  every corner: /w/class.1/ee/ee209b/ee209bta/TSMC180PDK/PDK/tsmc18/../models/spectre/cr018gpii_v1d0.scs[stat_noise]
  SS (off): cr018gpii_v1d0.scs[ss, ss_mim, ss_res, ss_bbmvar]
  FF (off): cr018gpii_v1d0.scs[ff, ff_mim, ff_res, ff_bbmvar]
  TT_noise (off): cr018gpii_v1d0.scs[tt, tt_mim, tt_bbmvar, tt_res]
