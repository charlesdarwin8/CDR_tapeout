ADE simulation setup
Run mode: Single Run, Sweeps and Corners
Tests:
  vineel_wk_209as_tb_Rp_inductor_1: vineel_wk/209as_tb_Rp_inductor/schematic, simulator spectre
    Variables: VDC = 1
    Outputs: Q
