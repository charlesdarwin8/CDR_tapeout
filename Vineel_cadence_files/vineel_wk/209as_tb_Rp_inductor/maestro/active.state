ADE simulation setup
Test vineel_wk_209as_tb_Rp_inductor_1: vineel_wk/209as_tb_Rp_inductor/schematic, simulator spectre
  Models: /w/class.1/ee/ee209b/ee209bta/TSMC180PDK/PDK/tsmc18/../models/spectre/cr018gpii_v1d0.scs[tt_rfres_sa, tt_rfmvar, tt_rtmom, tt_disres, tt, tt_rfesd, tt_mim, tt_fmom, tt_rfres_rpo, tt_m, tt_rfmim, tt_res, tt_bip, tt_bip3, tt_dio3, tt_3v, tt_na, tt_dio, tt_dio_m, tt_rfind, tt_dio_3m, tt_bbmvar, tt_rfres_hri, tt_3vna, tt_dio_dnw, tt_3m, tt_rfjvar, tt_rfmos, tt_rfsbd, tt_rfmvar_33, tt_rfmos33, tt_rffmom, stat_noise]
  Variables: VDC = 1
  Temperature: 27
  Analysis ac: start=5G stop=7G step=0.5G
  Output Rp = (-1 / real(ifreq('ac "/V0/PLUS")))
  Output Q = (-1 / real(ifreq('ac "/V0/PLUS")) / (2 * 3.14 * 6 * 1e+09 * 4 * 1e-09))
  Output ((2 * 3.14 * 6 * 1e+09 * 4 * 1e-09) / Q)
  Signals: /V0/PLUS (terminal), /V0/PLUS (terminal) as /V0/PLUS_V
Run mode: Single Run, Sweeps and Corners
