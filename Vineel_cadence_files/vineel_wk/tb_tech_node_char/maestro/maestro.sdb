ADE simulation setup
Run mode: Single Run, Sweeps and Corners
Tests:
  vineel_wk_tb_tech_node_char_1: vineel_wk/tb_tech_node_char/schematic, simulator spectre
    Variables: w = 2.25u; vdd = 1.8
    Outputs: VS("/V3")
