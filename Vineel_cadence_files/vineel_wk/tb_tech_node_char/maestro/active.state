ADE simulation setup
Test vineel_wk_tb_tech_node_char_1: vineel_wk/tb_tech_node_char/schematic, simulator spectre
  Models: /w/class.1/ee/ee209b/ee209bta/TSMC180PDK/PDK/tsmc18/../models/spectre/cr018gpii_v1d0.scs[tt_rfres_sa, tt_rfmvar, tt_rtmom, tt_disres, tt, tt_rfesd, tt_mim, tt_fmom, tt_rfres_rpo, tt_m, tt_rfmim, tt_res, tt_bip, tt_bip3, tt_dio3, tt_3v, tt_na, tt_dio, tt_dio_m, tt_rfind, tt_dio_3m, tt_bbmvar, tt_rfres_hri, tt_3vna, tt_dio_dnw, tt_3m, tt_rfjvar, tt_rfmos, tt_rfsbd, tt_rfmvar_33, tt_rfmos33, tt_rffmom, stat_noise]
  Variables: vdd = 1.8; w = 2.25u
  Temperature: 27
  Analysis tran: stop=1n errpreset=conservative
  Output VDC("/V1") (unticked)
  Output VDC("/V2") (unticked)
  Output VS("/V3") (unticked)
  Output VT("/va")
  Output VT("/vb")
  Output VT("/vc")
  Output VT("/vd")
  Output delay(?wf1 VT("/vb") ?value1 (VAR("vdd") / 2) ?edge1 "rising" ?nth1 1 ?td1 0.0 ?tol1 nil ?wf2 VT("/vc") ?value2 (VAR("vdd") / 2) ?edge2 "falling" ?nth2 1 ?tol2 nil ?td2 nil ?stop nil ?multiple nil)
  Output delay(?wf1 VT("/vb") ?value1 (VAR("vdd") / 2) ?edge1 "falling" ?nth1 1 ?td1 0.0 ?tol1 nil ?wf2 VT("/vc") ?value2 (VAR("vdd") / 2) ?edge2 "rising" ?nth2 1 ?tol2 nil ?td2 nil ?stop nil ?multiple nil)
  Signals: /V1, /V2, /va, /vd, /vb, /vc
Run mode: Single Run, Sweeps and Corners
