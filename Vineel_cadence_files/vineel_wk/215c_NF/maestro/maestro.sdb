ADE simulation setup
Run mode: Single Run, Sweeps and Corners
Tests:
  vineel_wk_215c_NF_1: vineel_wk/215c_NF/schematic, simulator spectre
    Variables: vrf = 20m
