ADE simulation setup
Run mode: Single Run, Sweeps and Corners
Tests:
  vineel_wk_209as_tb_varactor_char_1: vineel_wk/209as_tb_varactor_char/schematic, simulator spectre
    Variables: VDC = 1.8
    Outputs: (- (imag(ifreq('ac "/V0/PLUS")) / (2 * 3.1415 * 6e+09))); (- (imag(ifreq('ac "/V1/PLUS")) / (2 * 3.1415 * 6e+09))); (- (imag(ifreq('ac "/V3/PLUS")) / (2 * 3.1415 * 6e+09)))
