ADE simulation setup
Test vineel_wk_209as_tb_varactor_char_1: vineel_wk/209as_tb_varactor_char/schematic, simulator spectre
  Models: /w/class.1/ee/ee209b/ee209bta/TSMC180PDK/PDK/tsmc18/../models/spectre/cr018gpii_v1d0.scs[tt_rfres_sa, tt_rfmvar, tt_rtmom, tt_disres, tt, tt_rfesd, tt_mim, tt_fmom, tt_rfres_rpo, tt_m, tt_rfmim, tt_res, tt_bip, tt_bip3, tt_dio3, tt_3v, tt_na, tt_dio, tt_dio_m, tt_rfind, tt_dio_3m, tt_bbmvar, tt_rfres_hri, tt_3vna, tt_dio_dnw, tt_3m, tt_rfjvar, tt_rfmos, tt_rfsbd, tt_rfmvar_33, tt_rfmos33, tt_rffmom, stat_noise]
  Variables: VDC = 1.8
  Temperature: 27
  Analysis ac: sweep VDC start=0 stop=1.8 step=0.1 freq=6G
  Output (- (imag(ifreq('ac "/V0/PLUS")) / (2 * 3.1415 * 6e+09)))
  Output (- (imag(ifreq('ac "/V1/PLUS")) / (2 * 3.1415 * 6e+09)))
  Output (- (imag(ifreq('ac "/V3/PLUS")) / (2 * 3.1415 * 6e+09)))
  Signals: /V0/PLUS (terminal), /V1/PLUS (terminal), /V0/PLUS (terminal) as /V0/PLUS_V, /V1/PLUS (terminal) as /V1/PLUS_V
Run mode: Single Run, Sweeps and Corners
