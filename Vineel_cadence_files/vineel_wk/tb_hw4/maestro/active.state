ADE simulation setup
Test vineel_wk_tb_hw4_1: vineel_wk/tb_hw4/config, simulator spectre
  Models: /w/class.1/ee/ee209b/ee209bta/TSMC180PDK/PDK/tsmc18/../models/spectre/cr018gpii_v1d0.scs[tt_rfres_sa, tt_rfmvar, tt_rtmom, tt_disres, tt, tt_rfesd, tt_mim, tt_fmom, tt_rfres_rpo, tt_m, tt_rfmim, tt_res, tt_bip, tt_bip3, tt_dio3, tt_3v, tt_na, tt_dio, tt_dio_m, tt_rfind, tt_dio_3m, tt_bbmvar, tt_rfres_hri, tt_3vna, tt_dio_dnw, tt_3m, tt_rfjvar, tt_rfmos, tt_rfsbd, tt_rfmvar_33, tt_rfmos33, tt_rffmom, stat_noise]
  Variables: f = 500M; vdd = 1.8
  Temperature: 27
  Analysis tran: stop=50/VAR("f") errpreset=conservative maxstep=1p
  Output average(IT("/V0/PLUS"))
  Output VT("/CK")
  Output D_bus = awvCreateBus("D_bus" list(awvAnalog2Digital(VT("/D<7>") nil nil (VAR("vdd") / 2) nil "centre") awvAnalog2Digital(VT("/D<6>") nil nil (VAR("vdd") / 2) nil "centre") awvAnalog2Digital(VT("/D<5>") nil nil (VAR("vdd") / 2) nil "centre") awvAnalog2Digital(VT("/D<4>") nil nil (VAR("vdd") / 2) nil "centre") awvAnalog2Digital(VT("/D<3>") nil nil (VAR("vdd") / 2) nil "centre") awvAnalog2Digital(VT("/D<2>") nil nil (VAR("vdd") / 2) nil "centre") awvAnalog2Digital(VT("/D<1>") nil nil (VAR("vdd") / 2) nil "centre") awvAnalog2Digital(VT("/D<0>") nil nil (VAR("vdd") / 2) nil "centre")) "Binary")
  Output Q_bus = awvCreateBus("Q_bus" list(awvAnalog2Digital(VT("/Q<7>") nil nil (VAR("vdd") / 2) nil "centre") awvAnalog2Digital(VT("/Q<6>") nil nil (VAR("vdd") / 2) nil "centre") awvAnalog2Digital(VT("/Q<5>") nil nil (VAR("vdd") / 2) nil "centre") awvAnalog2Digital(VT("/Q<4>") nil nil (VAR("vdd") / 2) nil "centre") awvAnalog2Digital(VT("/Q<3>") nil nil (VAR("vdd") / 2) nil "centre") awvAnalog2Digital(VT("/Q<2>") nil nil (VAR("vdd") / 2) nil "centre") awvAnalog2Digital(VT("/Q<1>") nil nil (VAR("vdd") / 2) nil "centre") awvAnalog2Digital(VT("/Q<0>") nil nil (VAR("vdd") / 2) nil "centre")) "Binary")
  Output L1_bus = awvCreateBus("L1_bus" list(awvAnalog2Digital(VT("/I0/Flop<7>/V2") nil nil (VAR("vdd") / 2) nil "centre") awvAnalog2Digital(VT("/I0/Flop<6>/V2") nil nil (VAR("vdd") / 2) nil "centre") awvAnalog2Digital(VT("/I0/Flop<5>/V2") nil nil (VAR("vdd") / 2) nil "centre") awvAnalog2Digital(VT("/I0/Flop<4>/V2") nil nil (VAR("vdd") / 2) nil "centre") awvAnalog2Digital(VT("/I0/Flop<3>/V2") nil nil (VAR("vdd") / 2) nil "centre") awvAnalog2Digital(VT("/I0/Flop<2>/V2") nil nil (VAR("vdd") / 2) nil "centre") awvAnalog2Digital(VT("/I0/Flop<1>/V2") nil nil (VAR("vdd") / 2) nil "centre") awvAnalog2Digital(VT("/I0/Flop<0>/V2") nil nil (VAR("vdd") / 2) nil "centre")) "Binary")
  Output VT("/R")
  Output VT("/D<7:0>") (unticked)
  Output VT("/Q<7:0>") (unticked)
  Output VT("/I0/Flop<0>/V1") (unticked)
  Output VT("/I0/Flop<0>/V2") (unticked)
  Output VT("/I0/Flop<0>/V3") (unticked)
  Output VT("/Q<0>") (unticked)
  Signals: /CK, /V0/PLUS (terminal), /D<7:0>, /Q<7:0>, /I0/Flop<0>/V3, /I0/Flop<0>/V1, /I0/Flop<0>/V2, /I0/Flop<7>/V2, /I0/Flop<6>/V2, /I0/Flop<5>/V2, /I0/Flop<4>/V2, /I0/Flop<3>/V2, /I0/Flop<2>/V2, /I0/Flop<1>/V2, /R
Run mode: Single Run, Sweeps and Corners
