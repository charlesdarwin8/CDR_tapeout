ADE simulation setup
Run mode: Single Run, Sweeps and Corners
Tests:
  vineel_wk_tb_hw4_1: vineel_wk/tb_hw4/config, simulator spectre
    Variables: f = 500M; vdd = 1.8
