ADE simulation setup
Run mode: Single Run, Sweeps and Corners
Tests:
  vineel_wk_209as_vco_phase_noise_1: vineel_wk/209as_vco_phase_noise/config, simulator spectre
    Variables: vdd = 1.8; vctrl = 0.9
    Outputs: VT("/outb")
Corners:
  model folders: /w/class.1/ee/ee209b/ee209bta/TSMC180PDK/PDK/tsmc18/../models/spectre
  C0 (off): cr018gpii_v1d0.scs[ss, ss_mim, ss_res, ss_bbmvar, stat_noise]
  TT_noise: cr018gpii_v1d0.scs[tt, stat_noise, tt_mim, tt_bbmvar, tt_res]
