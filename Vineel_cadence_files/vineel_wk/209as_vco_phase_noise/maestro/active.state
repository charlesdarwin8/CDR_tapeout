ADE simulation setup
Test vineel_wk_209as_vco_phase_noise_1: vineel_wk/209as_vco_phase_noise/config, simulator spectre
  Models: /w/class.1/ee/ee209b/ee209bta/TSMC180PDK/PDK/tsmc18/../models/spectre/cr018gpii_v1d0.scs[tt_rfres_sa, tt_rfmvar, tt_rtmom, tt_disres, tt, tt_rfesd, tt_mim, tt_fmom, tt_rfres_rpo, tt_m, tt_rfmim, tt_res, tt_bip, tt_bip3, tt_dio3, tt_3v, tt_na, tt_dio, tt_dio_m, tt_rfind, tt_dio_3m, tt_bbmvar, tt_rfres_hri, tt_3vna, tt_dio_dnw, tt_3m, tt_rfjvar, tt_rfmos, tt_rfsbd, tt_rfmvar_33, tt_rfmos33, tt_rffmom, stat_noise]
  Variables: vctrl = 0.9; vdd = 1.8
  Temperature: 27
  Analysis tran: stop=10n errpreset=conservative
  Analysis pss: engine=Harmonic Balance fund=5.2G harms=20 oscana=t p=/out n=/outb errpreset=conservative
  Analysis pnoise: start=10k stop=1G dec=20 fund=5.2G p=/out n=/outb sweeptype=relative relharmnum=1 noisetype=timeaverage
  Analysis dc: (saves the operating point)
  Output VT("/out")
  Output VT("/outb")
  Output "freq(VT(\"/out\") \"rising\" ?xName \"cycle\" ?mode \"user\" ?threshold VAR(\"vdd\")/2)" = freq(VT("/out") "rising" ?xName "cycle" ?mode "user" ?threshold (VAR("vdd") / 2))
  Output Phase Noise; dBc/Hz, Relative Harmonic = 1 = pn('pnoise)
  Output (sqrt(integ((10**(pn('pnoise) / 10)) 1e+07 1e+09 " ")) / (6.28 * 6e+09))
  Signals: /out, /outb
Run mode: Single Run, Sweeps and Corners
Corners:
  model folders: /w/class.1/ee/ee209b/ee209bta/TSMC180PDK/PDK/tsmc18/../models/spectre
  C0 (off): cr018gpii_v1d0.scs[ss, ss_mim, ss_res, ss_bbmvar, stat_noise]
  TT_noise: cr018gpii_v1d0.scs[tt, stat_noise, tt_mim, tt_bbmvar, tt_res]
