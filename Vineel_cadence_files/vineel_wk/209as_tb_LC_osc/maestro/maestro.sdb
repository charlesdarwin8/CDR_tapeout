ADE simulation setup
Run mode: Single Run, Sweeps and Corners
Tests:
  vineel_wk_209as_tb_LC_osc_1: vineel_wk/209as_tb_LC_osc/config, simulator spectre
    Variables: vdd = 1.8; vctrl = {From/To}Auto:0.5:20:1.5{From/To}
    Outputs: i_avg; freq; avg_power; ((VT("/VO1") + VT("/VO2")) / 2)
