ADE simulation setup
Test vineel_wk_209as_tb_LC_osc_1: vineel_wk/209as_tb_LC_osc/config, simulator spectre
  Models: /w/class.1/ee/ee209b/ee209bta/TSMC180PDK/PDK/tsmc18/../models/spectre/cr018gpii_v1d0.scs[tt_rfres_sa, tt_rfmvar, tt_rtmom, tt_disres, tt, tt_rfesd, tt_mim, tt_fmom, tt_rfres_rpo, tt_m, tt_rfmim, tt_res, tt_bip, tt_bip3, tt_dio3, tt_3v, tt_na, tt_dio, tt_dio_m, tt_rfind, tt_dio_3m, tt_bbmvar, tt_rfres_hri, tt_3vna, tt_dio_dnw, tt_3m, tt_rfjvar, tt_rfmos, tt_rfsbd, tt_rfmvar_33, tt_rfmos33, tt_rffmom, stat_noise]
  Variables: vctrl = 0.5; vdd = 1.8
  Temperature: 27
  Analysis dc: (saves the operating point)
  Analysis tran: stop=20n errpreset=conservative
  Output i_avg = average(clip(IT("/V0/PLUS") 1e-08 1.5e-08))
  Output freq = average(freq(clip(VT("/VO1") 1e-08 1.5e-08) "rising" ?xName "cycle" ?mode "auto" ?threshold 0.0) ?continuous nil)
  Output avg_power = (average(clip(IT("/V0/PLUS") 1e-08 1.5e-08)) * 1.8)
  Output VO_avg = average(clip(((VT("/VO1") + VT("/VO2")) / 2) 1e-08 1.5e-08))
  Output Vo1_max = ymax(VT("/VO1"))
  Output Vo1_min = ymin(VT("/VO1"))
  Output pk-pk_swing = (ymax(VT("/VO1")) - ymin(VT("/VO1")))
  Output VT("/VO1")
  Output VT("/VO2")
  Output IT("/V0/PLUS")
  Output ((VT("/VO1") + VT("/VO2")) / 2)
  Output IT("/I0/M10/D")
  Output IT("/I0/M9/D")
  Output deriv(freq)
  Signals: /V0/PLUS (terminal), /VO1, /VO2
Run mode: Single Run, Sweeps and Corners
Setup values for test vineel_wk_209as_tb_LC_osc_1: vctrl = {From/To}Auto:0.5:20:1.5{From/To}
