ADE simulation setup
Test vineel_wk_209as_tb_LC_osc_1: vineel_wk/209as_tb_LC_osc/schematic, simulator spectre
  Models: /w/class.1/ee/ee209b/ee209bta/TSMC180PDK/PDK/tsmc18/../models/spectre/cr018gpii_v1d0.scs[ss_rfres_sa, ss_rfmvar, ss_rtmom, ss_disres, ss, ss_rfesd, ss_mim, ss_fmom, ss_rfres_rpo, ss_m, ss_rfmim, ss_res, ss_bip, ss_bip3, ss_dio3, ss_3v, ss_na, ss_dio, ss_dio_m, ss_rfind, ss_dio_3m, ss_bbmvar, ss_rfres_hri, ss_3vna, ss_dio_dnw, ss_3m, ss_rfjvar, ss_rfmos, ss_rfsbd, ss_rfmvar_33, ss_rfmos33, ss_rffmom, stat_noise]
  Temperature: 27
