ADE simulation setup
Run mode: Single Run, Sweeps and Corners
Tests:
  vineel_wk_tb_hw2_1: vineel_wk/tb_hw2/config, simulator spectre
    Variables: vdd = 1.8; f = {From/To}Linear:6G:0.5G:10G{From/To}
    Outputs: F_in over 2; frequency of 10th cycle
Corners:
  model folders: /w/class.1/ee/ee209b/ee209bta/TSMC180PDK/PDK/tsmc18/../models/spectre
  C0: cr018gpii_v1d0.scs[ss, stat_noise]
