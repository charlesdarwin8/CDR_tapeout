ADE simulation setup
Test vineel_wk_tb_hw2_1: vineel_wk/tb_hw2/config, simulator spectre
  Models: /w/class.1/ee/ee209b/ee209bta/TSMC180PDK/PDK/tsmc18/../models/spectre/cr018gpii_v1d0.scs[tt_rfres_sa, tt_rfmvar, tt_rtmom, tt_disres, tt, tt_rfesd, tt_mim, tt_fmom, tt_rfres_rpo, tt_m, tt_rfmim, tt_res, tt_bip, tt_bip3, tt_dio3, tt_3v, tt_na, tt_dio, tt_dio_m, tt_rfind, tt_dio_3m, tt_bbmvar, tt_rfres_hri, tt_3vna, tt_dio_dnw, tt_3m, tt_rfjvar, tt_rfmos, tt_rfsbd, tt_rfmvar_33, tt_rfmos33, tt_rffmom, stat_noise]
  Variables: f = {From/To}Linear:6G:0.5G:10G{From/To}; vdd = 1.8
  Temperature: 27
  Analysis tran: stop=30/VAR("f") errpreset=conservative maxstep=1p
  Output frequency of 10th cycle = value(freq(VT("/out1") "rising" ?xName "cycle" ?mode "auto" ?threshold 0.0) 10)
  Output F_in over 2 = (VAR("f") / 2)
  Output Average_current = average(clip(IT("/V0/PLUS") (3 / VAR("f")) (30 / VAR("f"))))
  Output freq(VT("/out1") "rising" ?xName "cycle" ?mode "auto" ?threshold 0.0)
  Output freq(VT("/out1") "rising" ?xName "cycle" ?mode "user" ?threshold 0.9)
  Output VT("/out1")
  Output VT("/out2")
  Output VT("/Va")
  Output VT("/Vb")
  Output VT("/CK")
  Output average(IT("/V0/PLUS"))
  Signals: /out1, /out2, /Va, /Vb, /CK, /V0/PLUS (terminal)
Run mode: Single Run, Sweeps and Corners
Corners:
  model folders: /w/class.1/ee/ee209b/ee209bta/TSMC180PDK/PDK/tsmc18/../models/spectre
  C0: cr018gpii_v1d0.scs[ss, stat_noise]
