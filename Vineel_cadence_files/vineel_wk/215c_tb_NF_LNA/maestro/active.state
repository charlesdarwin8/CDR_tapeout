ADE simulation setup
Test vineel_wk_215c_tb_NF_LNA_1: vineel_wk/215c_tb_NF_LNA/schematic, simulator spectre
  Models: /w/class.1/ee/ee209b/ee209bta/TSMC180PDK/PDK/tsmc18/../models/spectre/cr018gpii_v1d0.scs[tt_rfres_sa, tt_rfmvar, tt_rtmom, tt_disres, tt, tt_rfesd, tt_mim, tt_fmom, tt_rfres_rpo, tt_m, tt_rfmim, tt_res, tt_bip, tt_bip3, tt_dio3, tt_3v, tt_na, tt_dio, tt_dio_m, tt_rfind, tt_dio_3m, tt_bbmvar, tt_rfres_hri, tt_3vna, tt_dio_dnw, tt_3m, tt_rfjvar, tt_rfmos, tt_rfsbd, tt_rfmvar_33, tt_rfmos33, tt_rffmom, stat_noise]
  Variables: C_extra = 220f; vdd = 1.8; vrf = 20m
  Temperature: 27
  Analysis ac: center=2.44G span=1G lin=1000
  Analysis dc: (saves the operating point)
  Output output noise; V**2 / Hz = (getData("out" ?result "noise")**2) (unticked)
  Output input noise; V**2 / Hz = (getData("in" ?result "noise")**2) (unticked)
  Output pnoise gain = getData("gain" ?result "noise")
  Output VT("/net2") (unticked)
  Output getData("/NF" ?result "noise")
  Output (20 * log10(getData("gain" ?result "noise")))
  Output S11 dB20 = db(spm('sp 1 1))
  Output v /OUT; ac dB20(V) = db(vfreq('ac "/OUT"))
  Signals: /V0/PLUS (terminal)
Run mode: Single Run, Sweeps and Corners
