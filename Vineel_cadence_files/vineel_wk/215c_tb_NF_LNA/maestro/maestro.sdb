ADE simulation setup
Run mode: Single Run, Sweeps and Corners
Tests:
  vineel_wk_215c_tb_NF_LNA_1: vineel_wk/215c_tb_NF_LNA/schematic, simulator spectre
    Variables: vrf = 20m; vdd = 1.8; C_extra = 220f
