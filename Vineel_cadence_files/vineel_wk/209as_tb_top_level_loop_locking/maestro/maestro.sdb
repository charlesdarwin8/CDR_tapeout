ADE simulation setup
Run mode: Single Run, Sweeps and Corners
Tests:
  vineel_wk_209as_tb_top_level_loop_locking_1: vineel_wk/209as_tb_top_level_loop_locking/schematic, simulator spectre
    Variables: vdd = 1.8; del = 0; Vinit = 0.95
