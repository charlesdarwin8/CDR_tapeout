ADE simulation setup
Run mode: Single Run, Sweeps and Corners
Tests:
  vineel_wk_209as_tb_vco_1: vineel_wk/209as_tb_vco/schematic, simulator spectre
    Variables: vdd = 1.8; Vin = 1
    Outputs: VT("/out1")
