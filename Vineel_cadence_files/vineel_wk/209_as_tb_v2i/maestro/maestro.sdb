ADE simulation setup
Run mode: Single Run, Sweeps and Corners
Tests:
  vineel_wk_209_as_tb_v2i_1: vineel_wk/209_as_tb_v2i/schematic, simulator spectre
    Variables: vdd = 1.8; delay = 40p
    Outputs: IT("/V8/PLUS")
Corners:
  model folders: /w/class.1/ee/ee209b/ee209bta/TSMC180PDK/PDK/tsmc18/../models/spectre
  C0 (off): cr018gpii_v1d0.scs[ff]
