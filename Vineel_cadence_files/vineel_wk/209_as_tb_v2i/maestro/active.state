ADE simulation setup
Test vineel_wk_209_as_tb_v2i_1: vineel_wk/209_as_tb_v2i/schematic, simulator spectre
  Models: /w/class.1/ee/ee209b/ee209bta/TSMC180PDK/PDK/tsmc18/../models/spectre/cr018gpii_v1d0.scs[tt_rfres_sa, tt_rfmvar, tt_rtmom, tt_disres, tt, tt_rfesd, tt_mim, tt_fmom, tt_rfres_rpo, tt_m, tt_rfmim, tt_res, tt_bip, tt_bip3, tt_dio3, tt_3v, tt_na, tt_dio, tt_dio_m, tt_rfind, tt_dio_3m, tt_bbmvar, tt_rfres_hri, tt_3vna, tt_dio_dnw, tt_3m, tt_rfjvar, tt_rfmos, tt_rfsbd, tt_rfmvar_33, tt_rfmos33, tt_rffmom, stat_noise]
  Variables: delay = 40p; vdd = 1.8
  Temperature: 27
  Analysis tran: stop=100n errpreset=conservative
  Analysis dc: (saves the operating point)
  Output VT("/VINP")
  Output VT("/VINM")
  Output VT("/X")
  Output VT("/XB")
  Output IT("/V6/PLUS")
  Output IT("/V8/PLUS")
  Output IT("/V9/PLUS")
  Output IT("/V10/PLUS")
  Output average(IT("/V6/PLUS"))
  Output average(IT("/V8/PLUS"))
  Output average(IT("/V9/PLUS"))
  Output average(IT("/V10/PLUS"))
  Output IT("/V17/PLUS")
  Output VT("/S1")
  Output VT("/S2")
  Output VT("/S3")
  Output VT("/DIN")
  Output VT("/CLK")
  Signals: /X, /XB, /V6/PLUS (terminal), /V8/PLUS (terminal), /V9/PLUS (terminal), /V10/PLUS (terminal), /V17/PLUS (terminal), /S1, /S2, /S3, /DIN, /CLK
Run mode: Single Run, Sweeps and Corners
Corners:
  model folders: /w/class.1/ee/ee209b/ee209bta/TSMC180PDK/PDK/tsmc18/../models/spectre
  C0 (off): cr018gpii_v1d0.scs[ff]
