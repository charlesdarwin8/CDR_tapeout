ADE simulation setup
Run mode: Single Run, Sweeps and Corners
Tests:
  vineel_wk_209_as_tb_v2i_dc_1: vineel_wk/209_as_tb_v2i_dc/schematic, simulator spectre
    Variables: vdd = 1.8; vout = 0.9
