ADE simulation setup
Test vineel_wk_215c_tb_iip3_1: vineel_wk/215c_tb_iip3/schematic, simulator spectre
  Models: /w/class.1/ee/ee209b/ee209bta/TSMC180PDK/PDK/tsmc18/../models/spectre/cr018gpii_v1d0.scs[tt_rfres_sa, tt_rfmvar, tt_rtmom, tt_disres, tt, tt_rfesd, tt_mim, tt_fmom, tt_rfres_rpo, tt_m, tt_rfmim, tt_res, tt_bip, tt_bip3, tt_dio3, tt_3v, tt_na, tt_dio, tt_dio_m, tt_rfind, tt_dio_3m, tt_bbmvar, tt_rfres_hri, tt_3vna, tt_dio_dnw, tt_3m, tt_rfjvar, tt_rfmos, tt_rfsbd, tt_rfmvar_33, tt_rfmos33, tt_rffmom, stat_noise]
  Variables: C_extra = 220f; frf = 2.43G; prf = -20; vdd = 1.8; vrf = 20m
  Temperature: 27
  Analysis hb: funds=("RF1" "RF2") maxharms=("5" "5") tstab=auto errpreset=moderate
  Analysis dc: (saves the operating point)
  Output ipnCurves = ipnVRICurves((v("/IN" ?result "hb_mt_fi") - v("/VSS" ?result "hb_mt_fi")) '(2 -1) '(0 1) ?rport resultParam("PORT1:r" ?result "hb_mt_fi") ?epoint -40)
  Output Input Referred IP3 Point = ipnVRI((v("/IN" ?result "hb_mt_fi") - v("/VSS" ?result "hb_mt_fi")) '(2 -1) '(0 1) ?rport resultParam("PORT1:r" ?result "hb_mt_fi") ?epoint -40)
  Output 1st Order freq = "cadar(setof(x harmonicFreqList(?result \"hb_mt_fi\") equal(car(x) '(0 1))))"
  Signals: /V0/PLUS (terminal)
Run mode: Single Run, Sweeps and Corners
