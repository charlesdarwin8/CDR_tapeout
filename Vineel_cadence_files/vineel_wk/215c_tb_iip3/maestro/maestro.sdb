ADE simulation setup
Run mode: Single Run, Sweeps and Corners
Tests:
  vineel_wk_215c_tb_iip3_1: vineel_wk/215c_tb_iip3/schematic, simulator spectre
    Variables: vdd = 1.8; vrf = 20m; frf = 2.43G; prf = -20; C_extra = 220f
