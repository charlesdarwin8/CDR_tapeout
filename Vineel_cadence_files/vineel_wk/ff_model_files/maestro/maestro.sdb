ADE simulation setup
Run mode: Single Run, Sweeps and Corners
Tests:
  vineel_wk_209as_tb_LC_osc_1: vineel_wk/209as_tb_LC_osc/schematic, simulator spectre
