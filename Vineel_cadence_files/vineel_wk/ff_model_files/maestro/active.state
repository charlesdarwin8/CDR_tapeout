ADE simulation setup
Test vineel_wk_209as_tb_LC_osc_1: vineel_wk/209as_tb_LC_osc/schematic, simulator spectre
  Models: /w/class.1/ee/ee209b/ee209bta/TSMC180PDK/PDK/tsmc18/../models/spectre/cr018gpii_v1d0.scs[ff_rfres_sa, ff_rfmvar, ff_rtmom, ff_disres, ff_rfmos, ff_rfesd, ff_mim, ff_fmom, ff_rfres_rpo, ff_m, ff_rfmim, ff_res, ff_bip, ff_bip3, ff_dio3, ff_3v, ff_na, ff_dio, ff_dio_m, ff_rfind, ff_dio_3m, ff_bbmvar, ff_rfres_hri, ff_3vna, ff_dio_dnw, ff_3m, ff_rfjvar, ff_rfmos, ff_rfsbd, ff_rfmvar_33, ff_rfmos33, ff_rffmom, stat_noise]
  Temperature: 27
Run mode: Single Run, Sweeps and Corners
