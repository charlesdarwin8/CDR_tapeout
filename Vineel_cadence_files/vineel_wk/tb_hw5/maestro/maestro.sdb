ADE simulation setup
Run mode: Single Run, Sweeps and Corners
Tests:
  vineel_wk_tb_hw5_1: vineel_wk/tb_hw5/schematic, simulator spectre
    Variables: vdd = 1.8
    Outputs: VT("/VO1"); VT("/VO2"); freq
