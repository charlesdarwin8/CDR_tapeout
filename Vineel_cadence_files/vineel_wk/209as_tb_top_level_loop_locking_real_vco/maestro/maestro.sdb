ADE simulation setup
Run mode: Single Run, Sweeps and Corners
Tests:
  vineel_wk_209as_tb_top_level_loop_locking_real_vco_1: vineel_wk/209as_tb_top_level_loop_locking_real_vco/schematic, simulator spectre
    Variables: Vinit = 0.8; del = 0; vdd = 1.8
    Outputs: eye_leafValue(clip(VT("/CLK") 4e-06 8e-06) "Design_Point" 1.0)
