ADE simulation setup
Test vineel_wk_209as_tb_top_level_loop_locking_real_vco_1: vineel_wk/209as_tb_top_level_loop_locking_real_vco/schematic, simulator spectre
  Models: /w/class.1/ee/ee209b/ee209bta/TSMC180PDK/PDK/tsmc18/../models/spectre/cr018gpii_v1d0.scs[tt_rfres_sa, tt_rfmvar, tt_rtmom, tt_disres, tt, tt_rfesd, tt_mim, tt_fmom, tt_rfres_rpo, tt_m, tt_rfmim, tt_res, tt_bip, tt_bip3, tt_dio3, tt_3v, tt_na, tt_dio, tt_dio_m, tt_rfind, tt_dio_3m, tt_bbmvar, tt_rfres_hri, tt_3vna, tt_dio_dnw, tt_3m, tt_rfjvar, tt_rfmos, tt_rfsbd, tt_rfmvar_33, tt_rfmos33, tt_rffmom, stat_noise]
  Variables: Vinit = 0.8; del = 0; vdd = 1.8
  Temperature: 27
  Initial conditions: /vcap = Vinit; /vctrl = Vinit
  Analysis tran: stop=10u errpreset=conservative
  Output VT("/CLK")
  Output freq(VT("/CLK") "rising" ?xName "cycle" ?mode "user" ?threshold (VAR("vdd") / 2))
  Output VT("/DIN")
  Output VT("/vctrl")
  Output VT("/vcap")
  Output VT("/VINP")
  Output VT("/VINM")
  Output IT("/C0/PLUS")
  Output VT("/S1")
  Output VT("/S2")
  Output VT("/S3")
  Output VT("/S4")
  Output "leafValue(clip(VT(\"/CLK\") 4e-06 8e-06) \"Design_Point\" 1.0)" = clip(VT("/CLK") 4e-06 8e-06)
  Output "eye_leafValue(clip(VT(\"/CLK\") 4e-06 8e-06) \"Design_Point\" 1.0)" = eyeDiagram(clip(VT("/CLK") 5e-06 8e-06) 5e-06 8e-06 (2 * 3.33e-10) ?triggerPeriod 3.33e-10 ?autoCenter t ?intensityPlot t)
  Output average(clip(IT("/C0/PLUS") 4e-06 8e-06))
  Signals: /CLK, /DIN, /vctrl, /VINP, /VINM, /C0/PLUS (terminal), /S1, /S2, /S3, /vcap, /S4
Run mode: Single Run, Sweeps and Corners
