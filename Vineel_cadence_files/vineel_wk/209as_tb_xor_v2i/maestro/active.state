ADE simulation setup
Test vineel_wk_209as_tb_xor_v2i_1: vineel_wk/209as_tb_xor_v2i/schematic, simulator spectre
  Models: /w/class.1/ee/ee209b/ee209bta/TSMC180PDK/PDK/tsmc18/../models/spectre/cr018gpii_v1d0.scs[tt_rfres_sa, tt_rfmvar, tt_rtmom, tt_disres, tt, tt_rfesd, tt_mim, tt_fmom, tt_rfres_rpo, tt_m, tt_rfmim, tt_res, tt_bip, tt_bip3, tt_dio3, tt_3v, tt_na, tt_dio, tt_dio_m, tt_rfind, tt_dio_3m, tt_bbmvar, tt_rfres_hri, tt_3vna, tt_dio_dnw, tt_3m, tt_rfjvar, tt_rfmos, tt_rfsbd, tt_rfmvar_33, tt_rfmos33, tt_rffmom, stat_noise]
  Variables: vdd = 1.8
  Temperature: 27
  Analysis tran: stop=30n errpreset=conservative
  Output VT("/VINP")
  Output VT("/VINM")
  Output VT("/X")
  Output VT("/XB")
  Output IT("/V6/PLUS")
  Output IT("/V13/PLUS")
  Signals: /X, /XB, /V6/PLUS (terminal), /VINP, /VINM, /V13/PLUS (terminal)
Run mode: Single Run, Sweeps and Corners
Corners:
  model folders: /w/class.1/ee/ee209b/ee209bta/TSMC180PDK/PDK/tsmc18/../models/spectre
  C0 (off): cr018gpii_v1d0.scs[ff]
