ADE simulation setup
Run mode: Single Run, Sweeps and Corners
Tests:
  vineel_wk_209as_tb_top_level_loop_locking_verilogA_1: vineel_wk/209as_tb_top_level_loop_locking_verilogA/schematic, simulator spectre
    Variables: Vinit = 0.8; del = 0; vdd = 1.8; Gm = 240u; R_loop_filter = 300; C1 = 30p
    Outputs: eye_diagram_clock; average(clip(IT("/C0/PLUS") 2e-06 3e-06)); average(clip(IT("/C0/PLUS") 2.5e-06 5e-06))
