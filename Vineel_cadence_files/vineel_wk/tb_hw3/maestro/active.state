ADE simulation setup
Test vineel_wk_tb_hw3_1: vineel_wk/tb_hw3/config, simulator spectre
  Models: /w/class.1/ee/ee209b/ee209bta/TSMC180PDK/PDK/tsmc18/../models/spectre/cr018gpii_v1d0.scs[tt_rfres_sa, tt_rfmvar, tt_rtmom, tt_disres, tt, tt_rfesd, tt_mim, tt_fmom, tt_rfres_rpo, tt_m, tt_rfmim, tt_res, tt_bip, tt_bip3, tt_dio3, tt_3v, tt_na, tt_dio, tt_dio_m, tt_rfind, tt_dio_3m, tt_bbmvar, tt_rfres_hri, tt_3vna, tt_dio_dnw, tt_3m, tt_rfjvar, tt_rfmos, tt_rfsbd, tt_rfmvar_33, tt_rfmos33, tt_rffmom, stat_noise]
  Variables: Vin1 = 1; Vin2 = 1.01; f = 0.5G; vdd = 1.8
  Temperature: 27
  Analysis tran: stop=10/VAR("f") errpreset=conservative maxstep=1p
  Output Average_current = average(clip(IT("/V0/PLUS") (3 / VAR("f")) (10 / VAR("f"))))
  Output VT("/out1")
  Output VT("/out2")
  Output VT("/CK")
  Output average(IT("/V0/PLUS"))
  Output VT("/I2/V1")
  Output VT("/I2/V2")
  Output VT("/I2/VO1")
  Output VT("/I2/VO2")
  Output VT("/I2/V3") (unticked)
  Output delay(?wf1 VT("/CK") ?value1 (VAR("vdd") / 2) ?edge1 "rising" ?nth1 3 ?td1 0.0 ?tol1 nil ?wf2 VT("/out2") ?value2 (VAR("vdd") / 2) ?edge2 "rising" ?nth2 3 ?tol2 nil ?td2 nil ?stop nil ?multiple nil)
  Output IT("/V0/PLUS")
  Signals: /out2, /CK, /V0/PLUS (terminal), /I2/V1, /I2/V2, /I2/V3, /I2/VO1, /I2/VO2
Run mode: Single Run, Sweeps and Corners
