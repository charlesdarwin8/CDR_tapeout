ADE simulation setup
Run mode: Single Run, Sweeps and Corners
Tests:
  vineel_wk_tb_hw3_1: vineel_wk/tb_hw3/config, simulator spectre
    Variables: f = 0.5G; vdd = 1.8; Vin1 = 1; Vin2 = 1.01
    Outputs: Average_current
