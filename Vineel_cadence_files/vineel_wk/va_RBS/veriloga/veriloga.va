// VerilogA for vineel_wk, va_RBS, veriloga

`include "constants.vams"
`include "disciplines.vams"

module va_RBS(out);
    output out;
    electrical out;
    parameter real start = 0.0;
    parameter real period = 1.0;
    parameter real tr = 20p;
    parameter real vdd = 1.0;
    integer x;

    analog begin
	@(timer(start, period))
	    x = ($random >= 0) ? 1 : 0;
	V(out) <+ transition( x, 0.0,tr );
    end

endmodule
