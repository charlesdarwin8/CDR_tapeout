ADE simulation setup
Run mode: Single Run, Sweeps and Corners
Tests:
  vineel_wk_tb_mos_char_1: vineel_wk/tb_mos_char/schematic, simulator spectre
    Variables: vdd = 1.8; w = 500n; mul = 4; vdc = 0.9
    Outputs: (OS("/M1" "gm") / OS("/M1" "cgg") / 6.28)
Corners:
  model folders: /w/class.1/ee/ee209b/ee209bta/TSMC180PDK/PDK/tsmc18/../models/spectre
  C0 (off): cr018gpii_v1d0.scs[ss ff]
