ADE simulation setup
Test vineel_wk_tb_mos_char_1: vineel_wk/tb_mos_char/schematic, simulator spectre
  Models: /w/class.1/ee/ee209b/ee209bta/TSMC180PDK/PDK/tsmc18/../models/spectre/cr018gpii_v1d0.scs[tt_rfres_sa, tt_rfmvar, tt_rtmom, tt_disres, tt, tt_rfesd, tt_mim, tt_fmom, tt_rfres_rpo, tt_m, tt_rfmim, tt_res, tt_bip, tt_bip3, tt_dio3, tt_3v, tt_na, tt_dio, tt_dio_m, tt_rfind, tt_dio_3m, tt_bbmvar, tt_rfres_hri, tt_3vna, tt_dio_dnw, tt_3m, tt_rfjvar, tt_rfmos, tt_rfsbd, tt_rfmvar_33, tt_rfmos33, tt_rffmom, stat_noise]
  Variables: vdc = 0.9; mul = 4; w = 500n; vdd = 1.8
  Temperature: 27
  Operating points saved: /M1 (cgg gm gmoverid ft); /M8 (gmoverid gm cgg); /M5 (cgg gm gmoverid); /M27 (gmoverid gm)
  Analysis dc: (saves the operating point)
  Output OS("/M1" "ft")
  Output OS("/M1" "gmoverid")
  Output (OS("/M1" "gm") / OS("/M1" "cgg") / 6.28)
  Output IDC("/M9/D")
  Output (OS("/M8" "gm") / OS("/M8" "cgg"))
  Output OS("/M8" "gmoverid")
  Output OS("/M5" "gmoverid")
  Output (OS("/M5" "gm") / OS("/M5" "cgg"))
  Output OS("/M27" "gm")
  Output OS("/M27" "gmoverid")
  Signals: /M9/D (terminal)
Run mode: Single Run, Sweeps and Corners
Corners:
  model folders: /w/class.1/ee/ee209b/ee209bta/TSMC180PDK/PDK/tsmc18/../models/spectre
  C0 (off): cr018gpii_v1d0.scs[ss ff]
