ADE simulation setup
Run mode: Single Run, Sweeps and Corners
Tests:
  vineel_wk_209as_tb_R_1: vineel_wk/209as_tb_R/schematic, simulator spectre
    Outputs: (-1 / IDC("/V0/PLUS"))
