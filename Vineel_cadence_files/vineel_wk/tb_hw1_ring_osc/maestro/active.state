ADE simulation setup
Test vineel_wk_tb_hw1_ring_osc_1: vineel_wk/tb_hw1_ring_osc/config, simulator spectre
  Models: /w/class.1/ee/ee209b/ee209bta/TSMC180PDK/PDK/tsmc18/../models/spectre/cr018gpii_v1d0.scs[tt_rfres_sa, tt_rfmvar, tt_rtmom, tt_disres, tt, tt_rfesd, tt_mim, tt_fmom, tt_rfres_rpo, tt_m, tt_rfmim, tt_res, tt_bip, tt_bip3, tt_dio3, tt_3v, tt_na, tt_dio, tt_dio_m, tt_rfind, tt_dio_3m, tt_bbmvar, tt_rfres_hri, tt_3vna, tt_dio_dnw, tt_3m, tt_rfjvar, tt_rfmos, tt_rfsbd, tt_rfmvar_33, tt_rfmos33, tt_rffmom, stat_noise]
  Temperature: 27
  Analysis tran: stop=5n errpreset=conservative
  Output ring_osc_i_avg = average(clip(IT("/V0/PLUS") 1e-09 5e-09))
  Output ring_osc_freq = average(freq(clip(VT("/OUT3") 1e-09 5e-09) "rising" ?xName "cycle" ?mode "auto" ?threshold 0.0) ?continuous nil)
  Output ring_osc_avg_power = (average(clip(IT("/V0/PLUS") 1e-09 5e-09)) * 1.8)
  Output VT("/OUT1")
  Output VT("/OUT2")
  Output VT("/OUT3")
  Output IT("/V0/PLUS")
  Signals: /OUT1, /OUT2, /OUT3, /V0/PLUS (terminal)
Run mode: Single Run, Sweeps and Corners
