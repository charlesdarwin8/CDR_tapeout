ADE simulation setup
Run mode: Single Run, Sweeps and Corners
Tests:
  vineel_wk_tb_hw1_ring_osc_1: vineel_wk/tb_hw1_ring_osc/config, simulator spectre
